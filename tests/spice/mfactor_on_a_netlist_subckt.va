// H04 — E.4.1's multiplicity factor, applied to a subcircuit that came from a
// SPICE netlist. Four copies in parallel is four times the current.
//
// THE CLAUSE. E.4.1 "Multiplicity factor on subcircuits":
//
//     "Some SPICE simulators support a multiplicity factor (M) parameter on
//      subcircuits without the parameter being explicitly being declared. This
//      factor is typically used to indicate the subcircuit should be modeled as
//      if there are a specified number of copies in parallel. ... Starting with
//      LRM Version 2.2, the multiplicity factor is supported for subcircuits
//      defined as modules in Verilog-AMS using the hierarchical system parameter
//      $mfactor, as described in 6.3.6."
//
// E.2 makes a netlist subcircuit a module definition, so "subcircuits defined as
// modules" covers this one, and §6.3.6 supplies the arithmetic: every flow
// contributed inside the instance is multiplied by the resolved $mfactor. §9.18
// resolves it as `$mfactor_specified * $mfactor_hier`; the top of this hierarchy
// contributes 1.0, so the resolved value at `x1` is the 4 written on its
// instantiation.
//
// THE NETLIST is one card inside one subcircuit, so the only thing in motion is
// the factor:
//
//     .SUBCKT RUNIT A B
//     R1 A B 1K
//     .ENDS RUNIT
//
// THE DIGITS, BY HAND. `//! bias` holds a at 1.0 V and b at 0.0 V, so 1.0 V sits
// across the subcircuit's port pair. Inside, one Table E.1 resistor with no
// tc1/tc2, so its factor (1 + tc1*T + tc2*T^2) is 1 and it carries
//
//     I_one = V / r = 1.0 / 1000 = 1.0e-3 A
//
// §6.3.6 multiplies that contribution by the resolved $mfactor of 4:
//
//     flow into x1 at port a = 4 * 1.0e-3 = 4.0e-3 A
//
// which is the same current four such subcircuits in parallel would draw, which
// is what E.4.1 says M means.
//
// HOW THE FLOW IS READ (reconciler, 2026-10-08). An earlier revision read
// `I(x1.a, x1.b)`. §5.5.4 makes that a NEW unnamed branch in THIS module between
// the hierarchical nets — a flow probe, i.e. a short across the biased a/b pair —
// and not x1's resistor, so its digits were the harness's, not E.4.1's. The
// current x1 draws is read two ways that the LRM defines:
//   - `I(x1.branch(<a>))`: §5.5.5's hierarchical_unnamed_branch_reference to
//     x1's unnamed port branch for its port a (the clause's own example is
//     `I(top.drv.branch(<p>))`; §5.4.3 "accesses the flow into a port of a
//     module"; §6.7.1 "flow access for ... port branches can be done
//     hierarchically"): the flow into instance x1 through its port a. Not
//     `I(<x1.a>)`: §5.5.1 says a port probe's "port reference many not use
//     hierarchical specifications".
//   - `I(<a>)`: the flow into THIS module through its port a. Nothing but x1
//     touches a, so Kirchhoff at a gives the same 4.0e-3 A, read in a module
//     whose own $mfactor is 1 (§6.3.6's divide-on-probe rule is for probes in
//     the scaled instance's own analog block, and this is not one).
// The control x2 sits alone on c the same way: 1.0e-3 A both ways. `//! solve`
// frees the port-flow unknowns so Kirchhoff, not the harness, sets them; the
// three biased nets are each driven by the testbench, so the biased point is a
// solution of this circuit. `#(.$mfactor(4))` is A.4.1's own spelling for the
// override (§6.3.6 prints `module_b #(.$mfactor(2)) B1(p,n);`).
//
// WHAT VerA DOES TODAY, MEASURED. The equivalent written entirely in Verilog-AMS
// — `module runit(p,n); resistor #(.r(1k)) r1(p,n); endmodule` instantiated
// `runit #(.$mfactor(4)) x1(c,b);` — reports `I(x1.p,x1.n) got=0.001
// want=0.004`, and the residual at the node confirms it: `res[c] = 1.000000e-3`.
// So the factor is carried through elaboration (`Unit.mfactor`,
// `lib/ir/elaborate.zig`) and never reaches the contributions. The netlist path
// fails for that reason on top of fixture 06's empty body, so 06 has to be read
// first: if 06 is green and this is red, §6.3.6 is the cause on its own.
//
//! lrm E.4.1
//! lrm E.2
//! lrm 6.3.6
//! lrm 9.18
//! lrm 5.5.5
//! lrm 5.4.3
//! lrm 6.7.1
//! lrm 6.7.1:1
//! lrm E.4.1:1000
//! bias V(a) = 1.0, V(b) = 0.0, V(c) = 1.0
//! solve
//! checks 4
//! spice .SUBCKT RUNIT A B
//! spice R1 A B 1K
//! spice .ENDS RUNIT
`include "check.vh"
module h04_subckt_mfactor(a, b, c);
  inout a, b, c; electrical a, b, c;
  rUnit #(.$mfactor(4)) x1(a, b);
  // The SAME subcircuit with no override, on its own node pair at the same
  // 1.0 V: the control that makes the 4x attributable to $mfactor and to
  // nothing else. §9.18: an instance with no `.$mfactor` propagates the
  // parent's, which at the top of this hierarchy is 1.0.
  rUnit x2(c, b);
  analog begin
    `CHECKR("one unscaled copy is Table E.1's I = V/r = 1.0/1000 (flow into x2.a)",
            I(x2.branch(<a>)), 1.0e-3, 1e-12);
    `CHECKR("and the same current enters this module at c, which only x2 touches",
            I(<c>), 1.0e-3, 1e-12);
    // E.4.1's "a specified number of copies in parallel": four of them.
    `CHECKR("6.3.6 scales the subcircuit's flow by $mfactor: 4 * 1.0/1000 (flow into x1.a)",
            I(x1.branch(<a>)), 4.0e-3, 1e-12);
    `CHECKR("and the same current enters this module at a, which only x1 touches",
            I(<a>), 4.0e-3, 1e-12);
  end
endmodule
