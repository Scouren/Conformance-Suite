// E.3.2.2, the resolution half of primitive discipline:
//
//     If no attribute exists on the instance of an analog primitive, then the
//     discipline may be determined by the disciplines of other instances
//     connected to the same net segment. The disciplines of the vpiLoConn of all
//     other instances on the net segment shall be evaluated to determine if they
//     are of domain continuous and compatible with each other. If they are, then
//     the discipline of the analog primitive shall be set to the same discipline.
//     If they are not compatible, then an error will occur as defined in 3.11.
//     If there are no continuous disciplines defined on the net segment, then the
//     discipline shall default to electrical.
//
// E.3.2 lists the three levels this sits between: "A port_discipline attribute on
// the analog primitive; The resolution of the discipline; The default analog
// primitive of electrical."
//
// THE CIRCUIT. Three Table E.1 resistors, two of them on ONE net pair:
//
//     (* port_discipline="rotational" *) resistor #(.r(1k)) r1(shaft1, shaft2);
//                                        resistor #(.r(2k)) r2(shaft1, shaft2);
//                                        resistor #(.r(4k)) r3(u, v);
//
// `r1` is E.3.2.1's instance — the LRM's own `port_discipline` on the primitive.
// `r2` is the instance E.3.2.2 speaks about: no attribute of its own, and the
// segment it sits on already carries a continuous discipline. `u`/`v` occur
// nowhere but in `r3`'s instance and are declared by nothing, so THAT segment
// carries none, which is the clause's last sentence.
//
// HOW A DISCIPLINE IS OBSERVED. A behaviour cannot read a discipline back as a
// value; what a discipline decides is which access functions exist on the net.
// Annex D gives `rotational` the natures Angle and Angular_Force, whose access
// functions are Theta and Tau, where `electrical` has V and I. §5.4.3 names a
// port access function after "the flow nature of the discipline of the port",
// so `Tau(r2.branch(<p>))` — the flow into r2 through its own port p, read
// through §5.5.5's hierarchical_unnamed_branch_reference to r2's unnamed port
// branch (the clause's example is `I(top.drv.branch(<p>))`; §6.7.1 "flow
// access for ... port branches can be done hierarchically") — type-checks only
// if r2's port came out rotational, and `I(r3.branch(<p>))` only if r3's came
// out electrical. (Not `Tau(<r2.p>)`: §5.5.1 says a port probe's "port
// reference many not use hierarchical specifications".)
// A tool that left r2 on the electrical default, or refused the
// attribute-less instance, cannot reach those assertions at all (VerA's
// refusal, when the segment says nothing, is measured in
// primitive_segment_scan.va).
//
// THE DIGITS. Bias: Theta(shaft1) = 2.0 rad, Theta(shaft2) = 0.0, V(u) = 1.5,
// V(v) = 0.0. Table E.1's resistor row is V = I*r, written in the nature-neutral
// V/I of the table and holding in whatever discipline the ports end up in, so
// there Theta = Tau*r. Each primitive is its own branch, so each port flow is
// that primitive's own current and nothing else's:
//
//     into r2 at p:  Tau = 2.0/2000 = 1.0e-3
//     into r1 at p:  Tau = 2.0/1000 = 2.0e-3
//     into r3 at p:  I   = 1.5/4000 = 3.75e-4
//
// The potentials are read with §5.5.4 pair probes, `Theta(r2.p, r2.n)` and
// `V(r3.p, r3.n)`: each creates a new unnamed branch in THIS module between the
// hierarchical nets, a potential probe that draws no flow, so it reads the
// biased difference.
//
// RECONCILER, 2026-10-08. An earlier revision also read `Tau(r2.p, r2.n)` and
// `I(r3.p, r3.n)` and asserted 3.0e-3 for the first as "the flow of the net
// pair". Both were wrong: by §5.5.4 each is a new branch in this module, and
// reading the potential AND the flow of the same probe branch is illegal
// (§5.4.2.1, "Using both the potential and the flow of a probe branch is
// illegal"); nor does any clause make a pair probe the sum of two other
// modules' branches. The port flows above replace them. Until 2026-10-08 VerA
// read `I(<inst.port>)` as the parent net's own port flow, so `I(<r3.p>)` was
// E0508 (u is no top port) and `Tau(<r2.p>)` the top port's total, 3.0e-3; it
// now sums the instance's own contributions at the net (`lower/expr.zig`
// `instancePortFlow`), r2's share of the row it shares with r1 included.
// `//! solve` frees the port-flow unknowns so Kirchhoff, not the harness, sets
// them; every net stays biased, each driven by the testbench, so the biased
// point is a solution.
//
// WHAT IS NOT PINNED, and where it is pinned instead. The nets here are also
// DECLARED `rotational`, so this fixture cannot tell a tool that resolved r2 from
// the segment's declaration from one that ran E.3.2.2's scan over the other
// instances — both roads end at rotational, and the assertion is on the
// destination. primitive_discipline.va is where the attribute alone is
// load-bearing, and primitive_segment_scan.va is where the scan is: the same
// circuit with `shaft1`/`shaft2` left undeclared, so the attribute on r1 is the
// only place the discipline can come from. Nor is the §3.11 error of the
// incompatible case here: declaring two different continuous disciplines on one
// segment is an error a tool owes on the DECLARATION (§3.11), and the LRM's own
// E.3.2.1 example — printed on one pair with `electrical` on one instance and
// `rotational` on the other — is that example, not a circuit (see
// primitive_discipline.va).
//
//! lrm E.3.2.2
//! lrm E.3.2.2:1
//! lrm E.3.2.2:2
//! lrm E.3.2.2:3
//! lrm E.3.2.2:4
//! lrm E.3.2
//! lrm E.3.2.1
//! lrm E.1
//! lrm 5.4.1
//! lrm 5.4.3
//! lrm 5.5.4
//! lrm 5.5.5
//! lrm 6.7.1
//! lrm 6.5.7.2
//! lrm 6.5.7.2:1000
//! lrm 6.7.1:1
//! lrm E.3.2:1000
//! bias shaft1 = 2.0, shaft2 = 0.0, u = 1.5, v = 0.0
//! solve
//! checks 6
`include "check.vh"
module annex_e_primitive_segment_discipline(shaft1, shaft2);
  inout shaft1, shaft2;
  rotational shaft1, shaft2;
  (* port_discipline="rotational" *) resistor #(.r(1k)) r1(shaft1, shaft2);
  resistor #(.r(2k)) r2(shaft1, shaft2);
  resistor #(.r(4k)) r3(u, v);
  analog begin
    `CHECKX("r2 keeps its 2k", r2.r, 2000.0);
    // §5.5.4 potential probe across the segment's nets: 2 rad, as biased.
    `CHECKX("Theta reads across r2's nets", Theta(r2.p, r2.n), 2.0);
    // E.3.2.2: r2 has no attribute of its own; its port carries the segment's
    // discipline, so Tau is its port access function, and the flow is r2's own.
    `CHECKR("r2's port took the segment's discipline: Tau into r2 = 2/2000",
            Tau(r2.branch(<p>)), 1.0e-3, 1e-12);
    `CHECKR("r1 is a separate branch on the same nets: Tau into r1 = 2/1000",
            Tau(r1.branch(<p>)), 2.0e-3, 1e-12);
    // E.3.2.2, last sentence: u/v are declared by nothing and no instance on
    // them carries an attribute, so this segment defaults to electrical.
    `CHECKX("V reads across r3's nets", V(r3.p, r3.n), 1.5);
    `CHECKR("r3's segment defaults to electrical: I into r3 = 1.5/4000",
            I(r3.branch(<p>)), 3.75e-4, 1e-12);
  end
endmodule
