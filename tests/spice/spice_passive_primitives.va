// E.3, on connection BY ORDER: "Table E.1 shows the required names for
// primitives, parameters, and ports which are otherwise unnamed in SPICE. For
// connection by order instead of by name, the ports and parameters shall be
// given in the order listed." E.2 makes the primitives themselves required of a
// SPICE-compatible tool: "SPICE primitives built into the simulator shall be
// treated in the same manner in Verilog-AMS HDL as built-in primitives of gate-
// and switch-level modeling."
//
// WHAT IS PINNED. Table E.1's `resistor` BEHAVIOR column, with digits:
//
//     V = I * r * (1 + tc1*T + tc2*T^2)
//
// tc1 and tc2 are given as zero, which collapses the temperature polynomial to
// exactly 1 at every T and leaves the equation with no free reading: I = V/r.
// With `//! bias` holding p at 1 V and n at 0 V and r = 1k, the primitive shall
// carry 1.0/1000 = 1.0e-3 A from p to n. passive_named_ports.va gives tc1 and
// tc2 NONZERO and therefore cannot pin a current — see its header — so this is
// the file where the row's behaviour column is evaluated.
//
// The ordered connection is what the digit tests: the sign of the current says
// which net the FIRST positional port went to. A tool that read the list as
// (n, p) puts r1's port p on the 0 V net, reads -1.0e-3 there, and fails.
//
// HOW THE PRIMITIVE IS OBSERVED. §6.7.1: "Potential and flow access for named
// and unnamed branches (including port branches) can be done hierarchically",
// and "access of parameters can be done hierarchically". So `I(r1.branch(<p>))`,
// §5.5.5's hierarchical_unnamed_branch_reference to r1's unnamed port branch
// for p (the clause's example is `I(top.drv.branch(<p>))`; §5.4.3 "accesses
// the flow into a port of a module"), is the flow into the primitive through
// its port p (not `I(<r1.p>)`: §5.5.1 says a port probe's "port reference many
// not use hierarchical specifications") — the current the behaviour
// column fixes, entering at p and leaving at n — and `r1.r` is the parameter
// the `.r(1k)` override landed on.
//
// (Reconciler, 2026-10-08: an earlier revision read `I(r1.p, r1.n)`. §5.5.4
// makes that a NEW unnamed branch in THIS module between the hierarchical nets,
// a flow probe shorting the biased p/n pair, not r1's branch; its digit was the
// harness's. `//! solve` frees the port-flow unknown so Kirchhoff sets it; p
// and n stay biased, each driven by the testbench, so the point is a solution.) Table E.1 is what gives those two names:
// E.1.2, "when instantiating SPICE primitives in Verilog-AMS HDL, the primitives
// shall, and parameters and ports can, be named".
//
// THIS IS A RUN FIXTURE, NOT A REJECT. An earlier revision demanded a diagnostic
// here; that inverts the test, because the LRM prints the syntax and only a tool
// with no SPICE support would pass. E.2.2.3 prints this primitive ordered —
// `resistor #(.r(10k)) R1 (b1, gnd);`.
//
//! lrm E.3
//! lrm E.3:1
//! lrm E.2
//! lrm E.2:1
//! lrm E.2.2.3
//! lrm 5.5.5
//! lrm 5.4.3
//! lrm 6.7.1
//! lrm 6.2.2
//! lrm 6.2.2:2
//! lrm 6.3.3
//! lrm 6.3.3:1
//! lrm 6.5.4
//! lrm 6.5.4:1
//! lrm 6.7.1:1
//! bias V(p) = 1.0, V(n) = 0.0
//! solve
//! checks 4
`include "check.vh"
module annex_e_spice_passive_primitives(p, n);
  inout p, n; electrical p, n;
  resistor #(.r(1k), .tc1(0.0), .tc2(0.0)) r1(p, n);
  analog begin
    // §2.6.2 Table 2-1 gives `k` the value 1e3, so `1k` is 1000.0.
    `CHECKX("the r override reaches Table E.1's r parameter", r1.r, 1000.0);
    `CHECKX("tc1 is zero, so the linear temperature term vanishes", r1.tc1, 0.0);
    `CHECKX("tc2 is zero, so the quadratic term vanishes", r1.tc2, 0.0);
    // V = I*r*(1 + 0*T + 0*T^2)  =>  I = 1.0/1000. 1e-12 relative leaves a
    // tool room to evaluate the polynomial factor, stamp a conductance rather
    // than divide, and solve the port-flow row.
    `CHECKR("Table E.1: I = V/r = 1.0/1000, into r1 at p", I(r1.branch(<p>)), 1.0e-3, 1e-12);
  end
endmodule
