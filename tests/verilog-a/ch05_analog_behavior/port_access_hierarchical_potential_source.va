// §5.5.5: "To access an existing unnamed branch in another module instance,
// the hierarchical_unnamed_branch_reference syntax is used", Syntax 5-3's
// `hierarchical_inst_identifier.branch ( < port_identifier > )`, printed in the
// clause's example as `I(top.drv.branch(<p>))`, "the current flowing through
// the unnamed port branch for the port p in top.drv". §5.4.3: the port access
// "accesses the flow into a port of a module". So `I(u1.branch(<a>))` is the
// flow into instance u1 through its port a. Nothing in either clause depends
// on how u1 drives the port: through a potential source, the flow is that
// source's current.
//
// (Not `I(<u1.a>)`: §5.5.1 says a port probe's "port reference many not use
// hierarchical specifications, i.e., it must be a declared port of the module
// in which the port access function is used";
// port_access_hierarchical_port_rejected.va.)
//
// THE CIRCUIT. An internal net n joins u1, `V(a) <+ 0.5`, and u2,
// `I(a) <+ V(a) / r` with r = 1k. Nothing else touches n, so Kirchhoff's
// current law at n says the flows into the two ports sum to zero.
//
// BY HAND: V(n) = 0.5, so
//   I(u2.branch(<a>)) = 0.5 / 1000 = 5.0e-4   (u2 sinks it)
//   I(u1.branch(<a>)) = -5.0e-4               (u1 sources it: the flow INTO u1 is negative)
// Two checks.
//
// port_access_hierarchical_instance.va is the same read of an instance
// whose branch at the port is a flow source.
//
//! lrm 5.5.5
//! lrm 5.4.3
//! lrm 5.4.3:1002
//! lrm 6.7.1
//! solve
//! checks 2
`include "check.vh"
module pah_v(a);
  inout a; electrical a;
  analog V(a) <+ 0.5;
endmodule
module pah_g(a);
  inout a; electrical a;
  parameter real r = 1k;
  analog I(a) <+ V(a) / r;
endmodule
module pah_top;
  electrical n;
  pah_v u1(n);
  pah_g #(.r(1k)) u2(n);
  analog begin
    `CHECKR("u1 sources the flow through its potential source", I(u1.branch(<a>)), -5.0e-4, 1e-12);
    `CHECKR("u2 sinks it", I(u2.branch(<a>)), 5.0e-4, 1e-12);
  end
endmodule
